*
*  /home/eda/OpenLane/designs/project_scl_cp8d/alu8/5_klayout/lvs_drc/alu8.cdl : SPICE netlist for KLayout LVS translated from: /home/eda/OpenLane/designs/project_scl_cp8d/alu8/runs/RUN/results/routing/alu8_rt_pwr.v
*  Generated on 2026-10-22 21:14:11.565938
*
.INCLUDE core_iolib_cp8d.cdl

.SUBCKT ALU8 GROUND VDD GROUND VDD CARRY ZERO A[0] A[1] A[2] A[3] A[4] A[5] A[6] A[7] B[0] B[1] B[2] B[3] B[4] B[5] B[6] B[7] OP[0] OP[1] OP[2] RESULT[0] RESULT[1] RESULT[2] RESULT[3] RESULT[4] RESULT[5] RESULT[6] RESULT[7]

XFILLER0_0_0 GROUND VDD FILLER4
XFILLER0_0_100 GROUND VDD FILLER2
XFILLER0_0_116 GROUND VDD FILLER3
XFILLER0_0_124 GROUND VDD FILLER4
XFILLER0_0_128 GROUND VDD FILLER5
XFILLER0_0_130 GROUND VDD FILLER6
XFILLER0_0_135 GROUND VDD FILLER4
XFILLER0_0_139 GROUND VDD FILLER6
XFILLER0_0_143 GROUND VDD FILLER4
XFILLER0_0_151 GROUND VDD FILLER1
XFILLER0_0_16 GROUND VDD FILLER3
XFILLER0_0_183 GROUND VDD FILLER2
XFILLER0_0_199 GROUND VDD FILLER4
XFILLER0_0_203 GROUND VDD FILLER6
XFILLER0_0_24 GROUND VDD FILLER4
XFILLER0_0_28 GROUND VDD FILLER5
XFILLER0_0_38 GROUND VDD FILLER3
XFILLER0_0_4 GROUND VDD FILLER5
XFILLER0_0_46 GROUND VDD FILLER6
XFILLER0_0_59 GROUND VDD FILLER3
XFILLER0_0_67 GROUND VDD FILLER5
XFILLER0_0_78 GROUND VDD FILLER3
XFILLER0_0_86 GROUND VDD FILLER4
XFILLER0_0_90 GROUND VDD FILLER5
XFILLER0_0_92 GROUND VDD FILLER6
XFILLER0_10_0 GROUND VDD FILLER4
XFILLER0_10_105 GROUND VDD FILLER5
XFILLER0_10_113 GROUND VDD FILLER3
XFILLER0_10_121 GROUND VDD FILLER4
XFILLER0_10_125 GROUND VDD FILLER5
XFILLER0_10_142 GROUND VDD FILLER3
XFILLER0_10_150 GROUND VDD FILLER6
XFILLER0_10_154 GROUND VDD FILLER5
XFILLER0_10_156 GROUND VDD FILLER6
XFILLER0_10_165 GROUND VDD FILLER3
XFILLER0_10_17 GROUND VDD FILLER3
XFILLER0_10_173 GROUND VDD FILLER5
XFILLER0_10_184 GROUND VDD FILLER2
XFILLER0_10_200 GROUND VDD FILLER4
XFILLER0_10_25 GROUND VDD FILLER6
XFILLER0_10_32 GROUND VDD FILLER5
XFILLER0_10_4 GROUND VDD FILLER5
XFILLER0_10_47 GROUND VDD FILLER4
XFILLER0_10_51 GROUND VDD FILLER5
XFILLER0_10_53 GROUND VDD FILLER6
XFILLER0_10_60 GROUND VDD FILLER6
XFILLER0_10_70 GROUND VDD FILLER3
XFILLER0_10_78 GROUND VDD FILLER4
XFILLER0_10_82 GROUND VDD FILLER6
XFILLER0_10_89 GROUND VDD FILLER2
XFILLER0_12_0 GROUND VDD FILLER3
XFILLER0_12_102 GROUND VDD FILLER5
XFILLER0_12_104 GROUND VDD FILLER6
XFILLER0_12_118 GROUND VDD FILLER3
XFILLER0_12_126 GROUND VDD FILLER4
XFILLER0_12_130 GROUND VDD FILLER5
XFILLER0_12_132 GROUND VDD FILLER6
XFILLER0_12_140 GROUND VDD FILLER3
XFILLER0_12_148 GROUND VDD FILLER5
XFILLER0_12_165 GROUND VDD FILLER3
XFILLER0_12_173 GROUND VDD FILLER6
XFILLER0_12_184 GROUND VDD FILLER2
XFILLER0_12_200 GROUND VDD FILLER4
XFILLER0_12_21 GROUND VDD FILLER3
XFILLER0_12_29 GROUND VDD FILLER5
XFILLER0_12_31 GROUND VDD FILLER6
XFILLER0_12_38 GROUND VDD FILLER2
XFILLER0_12_60 GROUND VDD FILLER3
XFILLER0_12_68 GROUND VDD FILLER4
XFILLER0_12_8 GROUND VDD FILLER6
XFILLER0_12_84 GROUND VDD FILLER5
XFILLER0_12_90 GROUND VDD FILLER4
XFILLER0_12_94 GROUND VDD FILLER5
XFILLER0_12_96 GROUND VDD FILLER6
XFILLER0_14_0 GROUND VDD FILLER3
XFILLER0_14_103 GROUND VDD FILLER4
XFILLER0_14_107 GROUND VDD FILLER5
XFILLER0_14_113 GROUND VDD FILLER2
XFILLER0_14_129 GROUND VDD FILLER6
XFILLER0_14_141 GROUND VDD FILLER3
XFILLER0_14_149 GROUND VDD FILLER5
XFILLER0_14_151 GROUND VDD FILLER6
XFILLER0_14_156 GROUND VDD FILLER3
XFILLER0_14_164 GROUND VDD FILLER4
XFILLER0_14_168 GROUND VDD FILLER5
XFILLER0_14_179 GROUND VDD FILLER2
XFILLER0_14_195 GROUND VDD FILLER3
XFILLER0_14_20 GROUND VDD FILLER3
XFILLER0_14_203 GROUND VDD FILLER6
XFILLER0_14_28 GROUND VDD FILLER5
XFILLER0_14_42 GROUND VDD FILLER3
XFILLER0_14_63 GROUND VDD FILLER5
XFILLER0_14_65 GROUND VDD FILLER6
XFILLER0_14_70 GROUND VDD FILLER3
XFILLER0_14_78 GROUND VDD FILLER4
XFILLER0_14_87 GROUND VDD FILLER2
XFILLER0_16_0 GROUND VDD FILLER3
XFILLER0_16_101 GROUND VDD FILLER3
XFILLER0_16_109 GROUND VDD FILLER6
XFILLER0_16_127 GROUND VDD FILLER3
XFILLER0_16_135 GROUND VDD FILLER5
XFILLER0_16_145 GROUND VDD FILLER5
XFILLER0_16_147 GROUND VDD FILLER6
XFILLER0_16_168 GROUND VDD FILLER1
XFILLER0_16_20 GROUND VDD FILLER3
XFILLER0_16_200 GROUND VDD FILLER4
XFILLER0_16_28 GROUND VDD FILLER4
XFILLER0_16_32 GROUND VDD FILLER5
XFILLER0_16_45 GROUND VDD FILLER2
XFILLER0_16_61 GROUND VDD FILLER4
XFILLER0_16_65 GROUND VDD FILLER5
XFILLER0_16_71 GROUND VDD FILLER4
XFILLER0_16_75 GROUND VDD FILLER5
XFILLER0_16_77 GROUND VDD FILLER6
XFILLER0_16_86 GROUND VDD FILLER5
XFILLER0_16_88 GROUND VDD FILLER6
XFILLER0_18_0 GROUND VDD FILLER3
XFILLER0_18_106 GROUND VDD FILLER4
XFILLER0_18_12 GROUND VDD FILLER4
XFILLER0_18_124 GROUND VDD FILLER4
XFILLER0_18_128 GROUND VDD FILLER5
XFILLER0_18_130 GROUND VDD FILLER6
XFILLER0_18_139 GROUND VDD FILLER2
XFILLER0_18_155 GROUND VDD FILLER3
XFILLER0_18_163 GROUND VDD FILLER5
XFILLER0_18_168 GROUND VDD FILLER1
XFILLER0_18_20 GROUND VDD FILLER2
XFILLER0_18_200 GROUND VDD FILLER4
XFILLER0_18_46 GROUND VDD FILLER3
XFILLER0_18_54 GROUND VDD FILLER6
XFILLER0_18_66 GROUND VDD FILLER5
XFILLER0_18_81 GROUND VDD FILLER3
XFILLER0_18_89 GROUND VDD FILLER6
XFILLER0_18_98 GROUND VDD FILLER3
XFILLER0_20_0 GROUND VDD FILLER5
XFILLER0_20_102 GROUND VDD FILLER2
XFILLER0_20_118 GROUND VDD FILLER3
XFILLER0_20_126 GROUND VDD FILLER4
XFILLER0_20_130 GROUND VDD FILLER6
XFILLER0_20_144 GROUND VDD FILLER3
XFILLER0_20_152 GROUND VDD FILLER4
XFILLER0_20_156 GROUND VDD FILLER5
XFILLER0_20_158 GROUND VDD FILLER6
XFILLER0_20_172 GROUND VDD FILLER1
XFILLER0_20_19 GROUND VDD FILLER3
XFILLER0_20_2 GROUND VDD FILLER6
XFILLER0_20_27 GROUND VDD FILLER6
XFILLER0_20_41 GROUND VDD FILLER4
XFILLER0_20_45 GROUND VDD FILLER5
XFILLER0_20_47 GROUND VDD FILLER6
XFILLER0_20_54 GROUND VDD FILLER4
XFILLER0_20_62 GROUND VDD FILLER3
XFILLER0_20_70 GROUND VDD FILLER5
XFILLER0_20_76 GROUND VDD FILLER3
XFILLER0_20_84 GROUND VDD FILLER5
XFILLER0_20_86 GROUND VDD FILLER6
XFILLER0_20_91 GROUND VDD FILLER4
XFILLER0_20_95 GROUND VDD FILLER5
XFILLER0_22_0 GROUND VDD FILLER4
XFILLER0_22_116 GROUND VDD FILLER3
XFILLER0_22_124 GROUND VDD FILLER4
XFILLER0_22_128 GROUND VDD FILLER6
XFILLER0_22_13 GROUND VDD FILLER4
XFILLER0_22_135 GROUND VDD FILLER4
XFILLER0_22_139 GROUND VDD FILLER5
XFILLER0_22_141 GROUND VDD FILLER6
XFILLER0_22_153 GROUND VDD FILLER3
XFILLER0_22_161 GROUND VDD FILLER5
XFILLER0_22_174 GROUND VDD FILLER2
XFILLER0_22_190 GROUND VDD FILLER3
XFILLER0_22_198 GROUND VDD FILLER4
XFILLER0_22_202 GROUND VDD FILLER5
XFILLER0_22_25 GROUND VDD FILLER3
XFILLER0_22_4 GROUND VDD FILLER6
XFILLER0_22_41 GROUND VDD FILLER3
XFILLER0_22_56 GROUND VDD FILLER5
XFILLER0_22_58 GROUND VDD FILLER6
XFILLER0_22_63 GROUND VDD FILLER5
XFILLER0_22_69 GROUND VDD FILLER5
XFILLER0_22_79 GROUND VDD FILLER5
XFILLER0_22_81 GROUND VDD FILLER6
XFILLER0_22_86 GROUND VDD FILLER3
XFILLER0_22_98 GROUND VDD FILLER5
XFILLER0_24_0 GROUND VDD FILLER3
XFILLER0_24_100 GROUND VDD FILLER4
XFILLER0_24_104 GROUND VDD FILLER5
XFILLER0_24_117 GROUND VDD FILLER4
XFILLER0_24_12 GROUND VDD FILLER6
XFILLER0_24_121 GROUND VDD FILLER5
XFILLER0_24_132 GROUND VDD FILLER6
XFILLER0_24_146 GROUND VDD FILLER4
XFILLER0_24_150 GROUND VDD FILLER6
XFILLER0_24_155 GROUND VDD FILLER6
XFILLER0_24_167 GROUND VDD FILLER1
XFILLER0_24_199 GROUND VDD FILLER4
XFILLER0_24_203 GROUND VDD FILLER6
XFILLER0_24_21 GROUND VDD FILLER3
XFILLER0_24_29 GROUND VDD FILLER4
XFILLER0_24_39 GROUND VDD FILLER3
XFILLER0_24_47 GROUND VDD FILLER5
XFILLER0_24_53 GROUND VDD FILLER4
XFILLER0_24_57 GROUND VDD FILLER5
XFILLER0_24_67 GROUND VDD FILLER3
XFILLER0_24_75 GROUND VDD FILLER5
XFILLER0_24_77 GROUND VDD FILLER6
XFILLER0_24_8 GROUND VDD FILLER4
XFILLER0_24_82 GROUND VDD FILLER6
XFILLER0_24_91 GROUND VDD FILLER6
XFILLER0_26_0 GROUND VDD FILLER5
XFILLER0_26_115 GROUND VDD FILLER3
XFILLER0_26_123 GROUND VDD FILLER5
XFILLER0_26_125 GROUND VDD FILLER6
XFILLER0_26_129 GROUND VDD FILLER2
XFILLER0_26_145 GROUND VDD FILLER5
XFILLER0_26_159 GROUND VDD FILLER1
XFILLER0_26_19 GROUND VDD FILLER2
XFILLER0_26_191 GROUND VDD FILLER3
XFILLER0_26_199 GROUND VDD FILLER4
XFILLER0_26_2 GROUND VDD FILLER6
XFILLER0_26_203 GROUND VDD FILLER6
XFILLER0_26_47 GROUND VDD FILLER2
XFILLER0_26_63 GROUND VDD FILLER3
XFILLER0_26_71 GROUND VDD FILLER4
XFILLER0_26_83 GROUND VDD FILLER1
XFILLER0_28_0 GROUND VDD FILLER4
XFILLER0_28_108 GROUND VDD FILLER3
XFILLER0_28_116 GROUND VDD FILLER5
XFILLER0_28_129 GROUND VDD FILLER6
XFILLER0_28_13 GROUND VDD FILLER3
XFILLER0_28_144 GROUND VDD FILLER1
XFILLER0_28_176 GROUND VDD FILLER2
XFILLER0_28_192 GROUND VDD FILLER3
XFILLER0_28_200 GROUND VDD FILLER4
XFILLER0_28_21 GROUND VDD FILLER5
XFILLER0_28_31 GROUND VDD FILLER3
XFILLER0_28_4 GROUND VDD FILLER6
XFILLER0_28_47 GROUND VDD FILLER4
XFILLER0_28_51 GROUND VDD FILLER6
XFILLER0_28_65 GROUND VDD FILLER3
XFILLER0_28_73 GROUND VDD FILLER4
XFILLER0_28_89 GROUND VDD FILLER5
XFILLER0_28_91 GROUND VDD FILLER6
XFILLER0_2_0 GROUND VDD FILLER4
XFILLER0_2_103 GROUND VDD FILLER4
XFILLER0_2_107 GROUND VDD FILLER6
XFILLER0_2_128 GROUND VDD FILLER4
XFILLER0_2_13 GROUND VDD FILLER3
XFILLER0_2_138 GROUND VDD FILLER3
XFILLER0_2_150 GROUND VDD FILLER4
XFILLER0_2_154 GROUND VDD FILLER6
XFILLER0_2_168 GROUND VDD FILLER1
XFILLER0_2_200 GROUND VDD FILLER4
XFILLER0_2_21 GROUND VDD FILLER4
XFILLER0_2_25 GROUND VDD FILLER6
XFILLER0_2_39 GROUND VDD FILLER3
XFILLER0_2_4 GROUND VDD FILLER5
XFILLER0_2_47 GROUND VDD FILLER5
XFILLER0_2_49 GROUND VDD FILLER6
XFILLER0_2_54 GROUND VDD FILLER3
XFILLER0_2_62 GROUND VDD FILLER4
XFILLER0_2_66 GROUND VDD FILLER5
XFILLER0_2_68 GROUND VDD FILLER6
XFILLER0_2_81 GROUND VDD FILLER3
XFILLER0_2_89 GROUND VDD FILLER6
XFILLER0_2_97 GROUND VDD FILLER6
XFILLER0_30_0 GROUND VDD FILLER2
XFILLER0_30_100 GROUND VDD FILLER5
XFILLER0_30_110 GROUND VDD FILLER1
XFILLER0_30_142 GROUND VDD FILLER1
XFILLER0_30_16 GROUND VDD FILLER4
XFILLER0_30_174 GROUND VDD FILLER2
XFILLER0_30_190 GROUND VDD FILLER3
XFILLER0_30_198 GROUND VDD FILLER4
XFILLER0_30_202 GROUND VDD FILLER5
XFILLER0_30_28 GROUND VDD FILLER2
XFILLER0_30_44 GROUND VDD FILLER4
XFILLER0_30_48 GROUND VDD FILLER6
XFILLER0_30_53 GROUND VDD FILLER2
XFILLER0_30_69 GROUND VDD FILLER5
XFILLER0_30_71 GROUND VDD FILLER6
XFILLER0_30_80 GROUND VDD FILLER2
XFILLER0_30_96 GROUND VDD FILLER4
XFILLER0_4_0 GROUND VDD FILLER3
XFILLER0_4_107 GROUND VDD FILLER6
XFILLER0_4_115 GROUND VDD FILLER3
XFILLER0_4_123 GROUND VDD FILLER4
XFILLER0_4_127 GROUND VDD FILLER6
XFILLER0_4_135 GROUND VDD FILLER2
XFILLER0_4_14 GROUND VDD FILLER3
XFILLER0_4_151 GROUND VDD FILLER5
XFILLER0_4_153 GROUND VDD FILLER6
XFILLER0_4_167 GROUND VDD FILLER5
XFILLER0_4_172 GROUND VDD FILLER6
XFILLER0_4_179 GROUND VDD FILLER2
XFILLER0_4_195 GROUND VDD FILLER3
XFILLER0_4_203 GROUND VDD FILLER6
XFILLER0_4_22 GROUND VDD FILLER5
XFILLER0_4_24 GROUND VDD FILLER6
XFILLER0_4_35 GROUND VDD FILLER2
XFILLER0_4_51 GROUND VDD FILLER5
XFILLER0_4_53 GROUND VDD FILLER6
XFILLER0_4_60 GROUND VDD FILLER5
XFILLER0_4_62 GROUND VDD FILLER6
XFILLER0_4_70 GROUND VDD FILLER3
XFILLER0_4_78 GROUND VDD FILLER4
XFILLER0_4_82 GROUND VDD FILLER5
XFILLER0_4_90 GROUND VDD FILLER5
XFILLER0_4_92 GROUND VDD FILLER6
XFILLER0_4_99 GROUND VDD FILLER3
XFILLER0_6_0 GROUND VDD FILLER3
XFILLER0_6_113 GROUND VDD FILLER4
XFILLER0_6_117 GROUND VDD FILLER5
XFILLER0_6_127 GROUND VDD FILLER5
XFILLER0_6_129 GROUND VDD FILLER6
XFILLER0_6_143 GROUND VDD FILLER3
XFILLER0_6_151 GROUND VDD FILLER6
XFILLER0_6_164 GROUND VDD FILLER3
XFILLER0_6_172 GROUND VDD FILLER4
XFILLER0_6_183 GROUND VDD FILLER2
XFILLER0_6_199 GROUND VDD FILLER4
XFILLER0_6_203 GROUND VDD FILLER6
XFILLER0_6_25 GROUND VDD FILLER3
XFILLER0_6_33 GROUND VDD FILLER5
XFILLER0_6_44 GROUND VDD FILLER4
XFILLER0_6_48 GROUND VDD FILLER6
XFILLER0_6_55 GROUND VDD FILLER6
XFILLER0_6_62 GROUND VDD FILLER5
XFILLER0_6_64 GROUND VDD FILLER6
XFILLER0_6_70 GROUND VDD FILLER3
XFILLER0_6_78 GROUND VDD FILLER4
XFILLER0_6_82 GROUND VDD FILLER5
XFILLER0_6_97 GROUND VDD FILLER2
XFILLER0_8_0 GROUND VDD FILLER3
XFILLER0_8_100 GROUND VDD FILLER6
XFILLER0_8_112 GROUND VDD FILLER5
XFILLER0_8_120 GROUND VDD FILLER3
XFILLER0_8_128 GROUND VDD FILLER4
XFILLER0_8_13 GROUND VDD FILLER2
XFILLER0_8_132 GROUND VDD FILLER5
XFILLER0_8_134 GROUND VDD FILLER6
XFILLER0_8_142 GROUND VDD FILLER2
XFILLER0_8_168 GROUND VDD FILLER4
XFILLER0_8_172 GROUND VDD FILLER5
XFILLER0_8_174 GROUND VDD FILLER6
XFILLER0_8_181 GROUND VDD FILLER2
XFILLER0_8_197 GROUND VDD FILLER4
XFILLER0_8_201 GROUND VDD FILLER5
XFILLER0_8_203 GROUND VDD FILLER6
XFILLER0_8_29 GROUND VDD FILLER6
XFILLER0_8_40 GROUND VDD FILLER5
XFILLER0_8_45 GROUND VDD FILLER3
XFILLER0_8_53 GROUND VDD FILLER4
XFILLER0_8_57 GROUND VDD FILLER5
XFILLER0_8_63 GROUND VDD FILLER6
XFILLER0_8_72 GROUND VDD FILLER2
XFILLER0_8_8 GROUND VDD FILLER6
X_200_ OP[0] OP[2] OP[1] _187_ VDD GROUND NOR300
X_201_ OP[0] OP[2] OP[1] _188_ GROUND VDD OR3100
X_202_ _161_ _189_ _182_ GROUND VDD XNR200
X_203_ _139_ B[0] _183_ _190_ VDD GROUND ADNR00
X_204_ _182_ A[0] _134_ _191_ GROUND VDD ORND00
X_205_ _183_ _139_ B[0] _192_ GROUND VDD NND300
X_206_ _192_ _191_ _163_ _193_ GROUND VDD NND300
X_207_ _178_ _179_ _189_ _187_ _194_ VDD GROUND AOI400
X_208_ _183_ _184_ _167_ _186_ _195_ VDD GROUND AOI400
X_209_ _195_ _194_ _193_ _185_ _176_ RESULT[1] GROUND VDD NND500
X_210_ B[1] _153_ _143_ _196_ GROUND VDD MX2100
X_211_ B[1] _146_ _197_ VDD GROUND NOR200
X_212_ _136_ _197_ _196_ _198_ GROUND VDD MX2100
X_213_ _145_ _198_ _199_ VDD GROUND NOR200
X_214_ B[0] A[2] A[1] _000_ GROUND VDD MX2100
X_215_ B[1] _000_ _151_ _001_ GROUND VDD MX2100
X_216_ A[2] _136_ _002_ GROUND VDD AND200
X_217_ _002_ _003_ GROUND VDD INVR00
X_218_ B[2] _004_ A[2] GROUND VDD XNR200
X_219_ B[2] _005_ A[2] GROUND VDD XOR200
X_220_ _160_ A[2] B[2] _006_ GROUND VDD ORND00
X_221_ A[2] B[2] _007_ GROUND VDD NND200
X_222_ _007_ _008_ GROUND VDD INVR00
X_223_ _183_ _161_ _186_ _009_ VDD GROUND ADNR00
X_224_ _005_ _010_ _009_ GROUND VDD XNR200
X_225_ _191_ _181_ _005_ _011_ VDD GROUND ADNR00
X_226_ _004_ _190_ _180_ _012_ GROUND VDD ORND00
X_227_ _005_ _191_ _181_ _013_ GROUND VDD NND300
X_228_ _013_ _012_ _163_ _014_ GROUND VDD AND300
X_229_ _179_ _001_ _187_ _010_ _015_ VDD GROUND AOI400
X_230_ _199_ _014_ _016_ VDD GROUND NOR200
X_231_ _184_ _005_ _167_ _008_ _017_ VDD GROUND AOI400
X_232_ _017_ _016_ _015_ _006_ RESULT[2] GROUND VDD NND400
X_233_ _140_ B[3] _018_ GROUND VDD NND200
X_234_ B[3] _140_ _019_ VDD GROUND NOR200
X_235_ _140_ B[3] _020_ GROUND VDD OR2100
X_236_ _020_ _018_ _021_ GROUND VDD NND200
X_237_ _012_ _003_ _022_ GROUND VDD NND200
X_238_ _021_ _023_ _022_ GROUND VDD XNR200
X_239_ _023_ _163_ _024_ GROUND VDD NND200
X_240_ _007_ _009_ _004_ _025_ GROUND VDD ORND00
X_241_ _021_ _026_ _025_ GROUND VDD XOR200
X_242_ _026_ _187_ _027_ GROUND VDD NND200
X_243_ _135_ _172_ _170_ _028_ GROUND VDD MX2100
X_244_ B[1] _173_ _029_ VDD GROUND NOR200
X_245_ _136_ _029_ _028_ _030_ GROUND VDD MX2100
X_246_ _030_ _145_ _031_ GROUND VDD OR2100
X_247_ B[0] A[3] A[2] _032_ GROUND VDD MX2100
X_248_ B[1] _032_ _177_ _033_ GROUND VDD MX2100
X_249_ _033_ _179_ _034_ GROUND VDD NND200
X_250_ _160_ A[3] B[3] _035_ GROUND VDD ORND00
X_251_ A[3] B[3] _036_ GROUND VDD NND200
X_252_ _036_ _037_ GROUND VDD INVR00
X_253_ _184_ _021_ _167_ _037_ _038_ VDD GROUND AOI400
X_254_ _024_ _031_ _027_ _038_ _035_ _034_ RESULT[3] VDD GROUND NND600
X_255_ _141_ B[4] _039_ GROUND VDD NND200
X_256_ B[4] _141_ _040_ VDD GROUND NOR200
X_257_ _040_ _041_ GROUND VDD INVR00
X_258_ _041_ _039_ _042_ GROUND VDD AND200
X_259_ _041_ _039_ _043_ GROUND VDD NND200
X_260_ B[3] _140_ _012_ _003_ _044_ VDD GROUND AOI400
X_261_ _018_ _011_ _002_ _045_ GROUND VDD ORND00
X_262_ _045_ _020_ _043_ _046_ VDD GROUND ADNR00
X_263_ _042_ _044_ _019_ _047_ GROUND VDD ORND00
X_264_ _045_ _043_ _020_ _048_ GROUND VDD NND300
X_265_ _048_ _047_ _163_ _049_ GROUND VDD NND300
X_266_ _025_ _021_ _037_ _050_ VDD GROUND ADNR00
X_267_ _050_ _042_ _188_ _051_ VDD GROUND ADNR00
X_268_ _051_ _050_ _042_ _052_ GROUND VDD ORND00
X_269_ B[0] A[4] A[3] _053_ GROUND VDD MX2100
X_270_ B[1] _053_ _000_ _054_ GROUND VDD MX2100
X_271_ B[2] _054_ _055_ VDD GROUND NOR200
X_272_ _056_ _148_ _145_ _150_ _055_ VDD GROUND OAI400
X_273_ _056_ _152_ _136_ _057_ GROUND VDD ORND00
X_274_ _160_ A[4] B[4] _058_ GROUND VDD ORND00
X_275_ A[4] B[4] _059_ GROUND VDD NND200
X_276_ _167_ A[4] B[4] _060_ GROUND VDD AND300
X_277_ _043_ _184_ _060_ _061_ VDD GROUND ADNR00
X_278_ _061_ _058_ _057_ _052_ _049_ RESULT[4] GROUND VDD NND500
X_279_ _137_ A[5] _062_ VDD GROUND NOR200
X_280_ A[5] _137_ _063_ GROUND VDD NND200
X_281_ _063_ _064_ GROUND VDD INVR00
X_282_ _064_ _062_ _065_ GROUND VDD OR2100
X_283_ _065_ _066_ GROUND VDD INVR00
X_284_ _047_ _041_ _065_ _067_ VDD GROUND ADNR00
X_285_ _066_ _046_ _040_ _068_ GROUND VDD ORND00
X_286_ _065_ _047_ _041_ _069_ GROUND VDD NND300
X_287_ _069_ _068_ _163_ _070_ GROUND VDD NND300
X_288_ _059_ _050_ _042_ _071_ GROUND VDD ORND00
X_289_ _071_ _065_ _188_ _072_ VDD GROUND ADNR00
X_290_ _072_ _071_ _065_ _073_ GROUND VDD ORND00
X_291_ B[0] A[5] A[4] _074_ GROUND VDD MX2100
X_292_ B[1] _074_ _032_ _075_ GROUND VDD MX2100
X_293_ B[2] _075_ _178_ _076_ GROUND VDD MX2100
X_294_ _076_ _150_ _077_ GROUND VDD OR2100
X_295_ B[2] _145_ _078_ VDD GROUND NOR200
X_296_ _078_ _174_ _079_ GROUND VDD NND200
X_297_ A[5] B[5] _080_ GROUND VDD NND200
X_298_ _080_ _081_ GROUND VDD INVR00
X_299_ _160_ A[5] B[5] _082_ GROUND VDD ORND00
X_300_ _184_ _065_ _167_ _081_ _083_ VDD GROUND AOI400
X_301_ _083_ _082_ _079_ _077_ _084_ GROUND VDD AND400
X_302_ _084_ _073_ _070_ _085_ GROUND VDD AND300
X_303_ _085_ RESULT[5] GROUND VDD INVR00
X_304_ _138_ A[6] _086_ VDD GROUND NOR200
X_305_ A[6] _138_ _087_ GROUND VDD AND200
X_306_ A[6] _138_ _088_ GROUND VDD NND200
X_307_ _086_ _087_ _089_ VDD GROUND NOR200
X_308_ _087_ _086_ _090_ GROUND VDD OR2100
X_309_ _068_ _063_ _090_ _091_ VDD GROUND ADNR00
X_310_ _089_ _067_ _064_ _092_ GROUND VDD ORND00
X_311_ _090_ _068_ _063_ _093_ GROUND VDD NND300
X_312_ _093_ _092_ _163_ _094_ GROUND VDD NND300
X_313_ _071_ _065_ _081_ _095_ VDD GROUND ADNR00
X_314_ _095_ _089_ _188_ _096_ VDD GROUND ADNR00
X_315_ _096_ _095_ _089_ _097_ GROUND VDD ORND00
X_316_ B[0] A[6] A[5] _098_ GROUND VDD MX2100
X_317_ B[1] _098_ _053_ _099_ GROUND VDD MX2100
X_318_ B[2] _099_ _001_ _100_ GROUND VDD MX2100
X_319_ _100_ _150_ _101_ GROUND VDD OR2100
X_320_ _078_ _197_ _102_ GROUND VDD NND200
X_321_ _090_ _184_ _103_ GROUND VDD NND200
X_322_ A[6] B[6] _104_ GROUND VDD NND200
X_323_ _167_ A[6] B[6] _105_ GROUND VDD NND300
X_324_ _160_ A[6] B[6] _106_ GROUND VDD ORND00
X_325_ _106_ _105_ _103_ _102_ _101_ _107_ GROUND VDD AND500
X_326_ _107_ _097_ _094_ RESULT[6] GROUND VDD NND300
X_327_ B[7] _142_ _108_ VDD GROUND NOR200
X_328_ B[7] _109_ A[7] GROUND VDD XOR200
X_329_ _109_ _110_ GROUND VDD INVR00
X_330_ _109_ _092_ _088_ _111_ GROUND VDD NND300
X_331_ _110_ _091_ _087_ _112_ GROUND VDD ORND00
X_332_ _112_ _111_ _163_ _113_ GROUND VDD NND300
X_333_ _104_ _095_ _089_ _114_ GROUND VDD ORND00
X_334_ _114_ _109_ _115_ GROUND VDD AND200
X_335_ _109_ _114_ _116_ VDD GROUND NOR200
X_336_ _188_ _115_ _116_ _117_ GROUND VDD OR3100
X_337_ B[0] A[7] A[6] _118_ GROUND VDD MX2100
X_338_ B[1] _118_ _074_ _119_ GROUND VDD MX2100
X_339_ B[2] _119_ _033_ _120_ GROUND VDD MX2100
X_340_ _120_ _150_ _121_ GROUND VDD OR2100
X_341_ _078_ _029_ _122_ GROUND VDD NND200
X_342_ _109_ _184_ _123_ GROUND VDD NND200
X_343_ _167_ A[7] B[7] _124_ GROUND VDD NND300
X_344_ _160_ A[7] B[7] _125_ GROUND VDD ORND00
X_345_ _125_ _124_ _123_ _122_ _121_ _126_ GROUND VDD AND500
X_346_ _126_ _117_ _113_ RESULT[7] GROUND VDD NND300
X_347_ RESULT[2] RESULT[3] RESULT[4] RESULT[0] RESULT[1] _127_ GROUND VDD NOR500
X_348_ _127_ _107_ _097_ _094_ _085_ _128_ GROUND VDD AND500
X_349_ _128_ _126_ _117_ _113_ ZERO GROUND VDD AND400
X_350_ B[7] _142_ _092_ _088_ _129_ VDD GROUND AOI400
X_351_ _163_ _129_ _108_ _130_ GROUND VDD ORND00
X_352_ A[7] B[7] _115_ _131_ VDD GROUND ADNR00
X_353_ _130_ _131_ _188_ CARRY GROUND VDD ORND00
X_354_ OP[0] _132_ GROUND VDD INVR00
X_355_ OP[1] _133_ GROUND VDD INVR00
X_356_ B[0] _134_ GROUND VDD INVR00
X_357_ B[1] _135_ GROUND VDD INVR00
X_358_ B[2] _136_ GROUND VDD INVR00
X_359_ B[5] _137_ GROUND VDD INVR00
X_360_ B[6] _138_ GROUND VDD INVR00
X_361_ A[0] _139_ GROUND VDD INVR00
X_362_ A[3] _140_ GROUND VDD INVR00
X_363_ A[4] _141_ GROUND VDD INVR00
X_364_ A[7] _142_ GROUND VDD INVR00
X_365_ B[0] A[4] A[5] _143_ GROUND VDD MX2100
X_366_ _143_ _135_ _144_ GROUND VDD NND200
X_367_ OP[1] OP[2] _132_ _145_ GROUND VDD NND300
X_368_ B[0] A[6] A[7] _146_ GROUND VDD MX2100
X_369_ _146_ B[1] _147_ GROUND VDD NND200
X_370_ _147_ _144_ _148_ GROUND VDD NND200
X_371_ _145_ _148_ _149_ VDD GROUND NOR200
X_372_ _133_ OP[2] OP[0] _150_ GROUND VDD NND300
X_373_ A[0] _134_ _151_ GROUND VDD NND200
X_374_ B[1] _150_ _151_ _152_ VDD GROUND NOR300
X_375_ B[0] A[2] A[3] _153_ GROUND VDD MX2100
X_376_ _135_ _153_ _154_ VDD GROUND NOR200
X_377_ A[1] B[0] _155_ GROUND VDD NND200
X_378_ _155_ _151_ B[1] _156_ VDD GROUND ADNR00
X_379_ B[2] _154_ _156_ _157_ VDD GROUND NOR300
X_380_ _145_ _157_ _158_ VDD GROUND NOR200
X_381_ _159_ _149_ _136_ _152_ _158_ VDD GROUND OAI400
X_382_ _132_ OP[2] _133_ _160_ VDD GROUND NOR300
X_383_ A[0] B[0] _161_ GROUND VDD AND200
X_384_ OP[0] OP[1] _162_ VDD GROUND NOR200
X_385_ _132_ OP[2] OP[1] _163_ VDD GROUND NOR300
X_386_ _162_ _163_ _164_ VDD GROUND NOR200
X_387_ _161_ _164_ _165_ VDD GROUND NOR200
X_388_ _166_ A[0] B[0] _160_ _165_ VDD GROUND OAI400
X_389_ OP[0] OP[2] _133_ _167_ VDD GROUND NOR300
X_390_ _167_ _161_ _168_ GROUND VDD NND200
X_391_ _168_ _166_ _159_ RESULT[0] GROUND VDD NND300
X_392_ B[0] A[1] A[2] _169_ GROUND VDD MX2100
X_393_ B[0] A[3] A[4] _170_ GROUND VDD MX2100
X_394_ _135_ _170_ _169_ _171_ GROUND VDD MX2100
X_395_ B[0] A[5] A[6] _172_ GROUND VDD MX2100
X_396_ A[7] _134_ _173_ GROUND VDD NND200
X_397_ _135_ _173_ _172_ _174_ GROUND VDD MX2100
X_398_ _136_ _174_ _171_ _175_ GROUND VDD MX2100
X_399_ _175_ _145_ _176_ GROUND VDD OR2100
X_400_ A[1] _134_ _161_ _177_ VDD GROUND ADNR00
X_401_ B[1] _177_ _178_ VDD GROUND NOR200
X_402_ B[2] _150_ _179_ VDD GROUND NOR200
X_403_ A[1] _135_ _180_ GROUND VDD AND200
X_404_ A[1] _135_ _181_ GROUND VDD NND200
X_405_ B[1] _182_ A[1] GROUND VDD XNR200
X_406_ B[1] _183_ A[1] GROUND VDD XOR200
X_407_ _162_ OP[2] _184_ GROUND VDD AND200
X_408_ _160_ A[1] B[1] _185_ GROUND VDD ORND00
X_409_ A[1] B[1] _186_ GROUND VDD AND200

.ENDS ALU8
